* TB[pam4] .op/.ac S22 sweep (ngspice-45)
Vcc vcc 0 DC 4
Vcasc vcasc 0 DC 3.35
Vcmb vcmb 0 DC 1.9
Vblsb blsb 0 DC 15
Vbmsb bmsb 0 DC 15
XDUT lsbp lsbn msbp msbn outp outn vcc vcasc vcmb blsb bmsb pam4drv_pam4
Vslsbp slsbp 0 DC 1.9
Vslsbn slsbn 0 DC 1.9
Rslsbp slsbp lsbp 50
Rslsbn slsbn lsbn 50
Vsmsbp smsbp 0 DC 1.9
Vsmsbn smsbn 0 DC 1.9
Rsmsbp smsbp msbp 50
Rsmsbn smsbn msbn 50
Vsop outp vcc DC 0 AC 1 portnum 1 z0 50
Vson outn vcc DC 0 AC 1 portnum 2 z0 50
* post-layout adapter: pam4drv_pam4_lay -> pam4drv_pam4 schematic ports
.subckt pam4drv_pam4 lsbp lsbn msbp msbn outp outn vcc vcasc vcmb blsb bmsb
Xlay sub msbn lsbp vcmb lsbn msbp tmsb0 tlsb0 tmsb1 vcasc outp outn vcc pam4drv_pam4_lay
Gtlsb0 tlsb0 0 blsb 0 1m
Gtmsb0 tmsb0 0 bmsb 0 1m
Gtmsb1 tmsb1 0 bmsb 0 1m
Vsub sub 0 DC 0
.ends pam4drv_pam4
.include "../../../report/layout/c/dut_pam4_post.spice"
.lib "cornerRES.lib" res_typ
.lib "cornerCAP.lib" cap_typ

.lib "cornerHBT.lib" hbt_typ
.options gmin=1e-12 reltol=1e-3
* independent method: ngspice built-in S-parameter analysis, 2 ports (outp, outn), z0 = 50
.control
op
sp dec 100 1e8 1e11
let sdd22 = 0.5*(S_1_1 - S_1_2 - S_2_1 + S_2_2)
let sdd22db = db(sdd22)
wrdata s22_sp.csv sdd22db
.endc
.GLOBAL GND
.end
