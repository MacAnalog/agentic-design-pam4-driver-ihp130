* TB[lsb] .op/sp S21+S11 sweep drive=in (ngspice-45)
Vcc vcc 0 DC 4
Vcasc vcasc 0 DC 3.25
Vcmb vcmb 0 DC 1.9
Vbias bias 0 DC 16
XDUT inp inn outp outn vcc vcasc vcmb bias pam4drv_lsb
Vlp outp vcc DC 0 AC 0 portnum 3 z0 50
Vln outn vcc DC 0 AC 0 portnum 4 z0 50
Vsinp inp 0 DC 1.9 AC 1 portnum 1 z0 50
Vsinn inn 0 DC 1.9 AC 1 portnum 2 z0 50
.include ../dut/dut_lsb.spice
.lib "cornerHBT.lib" hbt_typ
.options gmin=1e-12 reltol=1e-3
.control
op
print v(outp) v(outn) i(Vcc)
sp dec 20 1e+08 1e+11
let s21db = db(0.5*(S_3_1 - S_3_2 - S_4_1 + S_4_2))
let s11db = db(0.5*(S_1_1 - S_1_2 - S_2_1 + S_2_2))
wrdata ac.csv s21db s11db
.endc
.GLOBAL GND
.end
