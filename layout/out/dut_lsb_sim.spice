* pre-layout sim netlist for pam4drv_lsb_lay — same devices as the LVS reference, on the PDK models
* (rsil / cap_cmim / npn13G2 subckts; tails + sub are ports)
.subckt pam4drv_lsb_lay inp inn outp outn vcc vcasc vcmb tail sub
XQ1L0 c1L0 inp e1L0 sub npn13G2 Nx=3
XQ2L0 c2L0 inn e2L0 sub npn13G2 Nx=3
XQ3L0 outp vcasc c1L0 sub npn13G2 Nx=3
XQ4L0 outn vcasc c2L0 sub npn13G2 Nx=3
XRRE1L0 e1L0 tail sub rsil w=4.61u l=0.85u m=1
XRRE2L0 e2L0 tail sub rsil w=4.61u l=0.85u m=1
XRRbinp inp vcmb sub rsil w=0.58u l=2.85u m=1
XRRbinn inn vcmb sub rsil w=0.58u l=2.85u m=1
XRRcp outp vcc sub rsil w=1.01u l=5.43u m=1
XRRcn outn vcc sub rsil w=1.01u l=5.43u m=1
XCdegL0 e2L0 e1L0 cap_cmim w=3.45u l=3.45u
.ends
