* LVS reference for pam4drv_lsb_lay (generated by gen_layout.py — matches the GDS exactly)
.subckt pam4drv_lsb_lay inp inn outp outn vcc vcasc vcmb tail sub
QQ1L0 c1L0 inp e1L0 sub npn13G2 AE=0.063p PE=1.94u M=3
QQ2L0 c2L0 inn e2L0 sub npn13G2 AE=0.063p PE=1.94u M=3
QQ3L0 outp vcasc c1L0 sub npn13G2 AE=0.063p PE=1.94u M=3
QQ4L0 outn vcasc c2L0 sub npn13G2 AE=0.063p PE=1.94u M=3
RRE1L0 e1L0 tail sub rsil w=6.13u l=1.81u m=1
RRE2L0 e2L0 tail sub rsil w=6.13u l=1.81u m=1
RRbinp inp vcmb sub rsil w=0.55u l=2.72u m=1
RRbinn inn vcmb sub rsil w=0.55u l=2.72u m=1
RRcp outp vcc sub rsil w=1.13u l=6.44u m=1
RRcn outn vcc sub rsil w=1.13u l=6.44u m=1
CCdegL0 e2L0 e1L0 cap_cmim W=3.67u L=3.67u M=1
.ends
